* NGSPICE file created from uart_top.ext - technology: sky130A

* Black-box entry subcircuit for sky130_fd_sc_hd__decap_4 abstract view
.subckt sky130_fd_sc_hd__decap_4 VGND VNB VPB VPWR
.ends

* Black-box entry subcircuit for sky130_fd_sc_hd__fill_2 abstract view
.subckt sky130_fd_sc_hd__fill_2 VGND VNB VPB VPWR
.ends

* Black-box entry subcircuit for sky130_fd_sc_hd__dfstp_1 abstract view
.subckt sky130_fd_sc_hd__dfstp_1 CLK D SET_B VGND VNB VPB VPWR Q
.ends

* Black-box entry subcircuit for sky130_fd_sc_hd__mux2_1 abstract view
.subckt sky130_fd_sc_hd__mux2_1 A0 A1 S VGND VNB VPB VPWR X
.ends

* Black-box entry subcircuit for sky130_fd_sc_hd__nor3_1 abstract view
.subckt sky130_fd_sc_hd__nor3_1 A B C VGND VNB VPB VPWR Y
.ends

* Black-box entry subcircuit for sky130_fd_sc_hd__clkbuf_4 abstract view
.subckt sky130_fd_sc_hd__clkbuf_4 A VGND VNB VPB VPWR X
.ends

* Black-box entry subcircuit for sky130_fd_sc_hd__fill_1 abstract view
.subckt sky130_fd_sc_hd__fill_1 VGND VNB VPB VPWR
.ends

* Black-box entry subcircuit for sky130_fd_sc_hd__dfrtp_1 abstract view
.subckt sky130_fd_sc_hd__dfrtp_1 CLK D RESET_B VGND VNB VPB VPWR Q
.ends

* Black-box entry subcircuit for sky130_fd_sc_hd__a22o_1 abstract view
.subckt sky130_fd_sc_hd__a22o_1 A1 A2 B1 B2 VGND VNB VPB VPWR X
.ends

* Black-box entry subcircuit for sky130_fd_sc_hd__decap_3 abstract view
.subckt sky130_fd_sc_hd__decap_3 VGND VNB VPB VPWR
.ends

* Black-box entry subcircuit for sky130_fd_sc_hd__decap_8 abstract view
.subckt sky130_fd_sc_hd__decap_8 VGND VNB VPB VPWR
.ends

* Black-box entry subcircuit for sky130_fd_sc_hd__decap_6 abstract view
.subckt sky130_fd_sc_hd__decap_6 VGND VNB VPB VPWR
.ends

* Black-box entry subcircuit for sky130_fd_sc_hd__or2_1 abstract view
.subckt sky130_fd_sc_hd__or2_1 A B VGND VNB VPB VPWR X
.ends

* Black-box entry subcircuit for sky130_fd_sc_hd__clkbuf_1 abstract view
.subckt sky130_fd_sc_hd__clkbuf_1 A VGND VNB VPB VPWR X
.ends

* Black-box entry subcircuit for sky130_fd_sc_hd__dfrtp_4 abstract view
.subckt sky130_fd_sc_hd__dfrtp_4 CLK D RESET_B VGND VNB VPB VPWR Q
.ends

* Black-box entry subcircuit for sky130_fd_sc_hd__inv_2 abstract view
.subckt sky130_fd_sc_hd__inv_2 A VGND VNB VPB VPWR Y
.ends

* Black-box entry subcircuit for sky130_fd_sc_hd__o221a_1 abstract view
.subckt sky130_fd_sc_hd__o221a_1 A1 A2 B1 B2 C1 VGND VNB VPB VPWR X
.ends

* Black-box entry subcircuit for sky130_fd_sc_hd__clkbuf_16 abstract view
.subckt sky130_fd_sc_hd__clkbuf_16 A VGND VNB VPB VPWR X
.ends

* Black-box entry subcircuit for sky130_fd_sc_hd__dfrtp_2 abstract view
.subckt sky130_fd_sc_hd__dfrtp_2 CLK D RESET_B VGND VNB VPB VPWR Q
.ends

* Black-box entry subcircuit for sky130_fd_sc_hd__buf_4 abstract view
.subckt sky130_fd_sc_hd__buf_4 A VGND VNB VPB VPWR X
.ends

* Black-box entry subcircuit for sky130_fd_sc_hd__nor2b_2 abstract view
.subckt sky130_fd_sc_hd__nor2b_2 A B_N VGND VNB VPB VPWR Y
.ends

* Black-box entry subcircuit for sky130_fd_sc_hd__o21ai_1 abstract view
.subckt sky130_fd_sc_hd__o21ai_1 A1 A2 B1 VGND VNB VPB VPWR Y
.ends

* Black-box entry subcircuit for sky130_fd_sc_hd__nand2_2 abstract view
.subckt sky130_fd_sc_hd__nand2_2 A B VGND VNB VPB VPWR Y
.ends

* Black-box entry subcircuit for sky130_fd_sc_hd__o21a_1 abstract view
.subckt sky130_fd_sc_hd__o21a_1 A1 A2 B1 VGND VNB VPB VPWR X
.ends

* Black-box entry subcircuit for sky130_fd_sc_hd__nand2_1 abstract view
.subckt sky130_fd_sc_hd__nand2_1 A B VGND VNB VPB VPWR Y
.ends

* Black-box entry subcircuit for sky130_ef_sc_hd__decap_12 abstract view
.subckt sky130_ef_sc_hd__decap_12 VPWR VGND VPB VNB
.ends

* Black-box entry subcircuit for sky130_fd_sc_hd__and4bb_1 abstract view
.subckt sky130_fd_sc_hd__and4bb_1 A_N B_N C D VGND VNB VPB VPWR X
.ends

* Black-box entry subcircuit for sky130_fd_sc_hd__or2b_1 abstract view
.subckt sky130_fd_sc_hd__or2b_1 A B_N VGND VNB VPB VPWR X
.ends

* Black-box entry subcircuit for sky130_fd_sc_hd__nand3_1 abstract view
.subckt sky130_fd_sc_hd__nand3_1 A B C VGND VNB VPB VPWR Y
.ends

* Black-box entry subcircuit for sky130_fd_sc_hd__tapvpwrvgnd_1 abstract view
.subckt sky130_fd_sc_hd__tapvpwrvgnd_1 VGND VPWR
.ends

* Black-box entry subcircuit for sky130_fd_sc_hd__xor2_1 abstract view
.subckt sky130_fd_sc_hd__xor2_1 A B VGND VNB VPB VPWR X
.ends

* Black-box entry subcircuit for sky130_fd_sc_hd__o21ba_1 abstract view
.subckt sky130_fd_sc_hd__o21ba_1 A1 A2 B1_N VGND VNB VPB VPWR X
.ends

* Black-box entry subcircuit for sky130_fd_sc_hd__buf_1 abstract view
.subckt sky130_fd_sc_hd__buf_1 A VGND VNB VPB VPWR X
.ends

* Black-box entry subcircuit for sky130_fd_sc_hd__a32o_1 abstract view
.subckt sky130_fd_sc_hd__a32o_1 A1 A2 A3 B1 B2 VGND VNB VPB VPWR X
.ends

* Black-box entry subcircuit for sky130_fd_sc_hd__dlygate4sd3_1 abstract view
.subckt sky130_fd_sc_hd__dlygate4sd3_1 A VGND VNB VPB VPWR X
.ends

* Black-box entry subcircuit for sky130_fd_sc_hd__a21oi_1 abstract view
.subckt sky130_fd_sc_hd__a21oi_1 A1 A2 B1 VGND VNB VPB VPWR Y
.ends

* Black-box entry subcircuit for sky130_fd_sc_hd__and3_1 abstract view
.subckt sky130_fd_sc_hd__and3_1 A B C VGND VNB VPB VPWR X
.ends

* Black-box entry subcircuit for sky130_fd_sc_hd__a21o_1 abstract view
.subckt sky130_fd_sc_hd__a21o_1 A1 A2 B1 VGND VNB VPB VPWR X
.ends

* Black-box entry subcircuit for sky130_fd_sc_hd__and4_1 abstract view
.subckt sky130_fd_sc_hd__and4_1 A B C D VGND VNB VPB VPWR X
.ends

* Black-box entry subcircuit for sky130_fd_sc_hd__nor2_1 abstract view
.subckt sky130_fd_sc_hd__nor2_1 A B VGND VNB VPB VPWR Y
.ends

* Black-box entry subcircuit for sky130_fd_sc_hd__and2b_1 abstract view
.subckt sky130_fd_sc_hd__and2b_1 A_N B VGND VNB VPB VPWR X
.ends

* Black-box entry subcircuit for sky130_fd_sc_hd__nor2_2 abstract view
.subckt sky130_fd_sc_hd__nor2_2 A B VGND VNB VPB VPWR Y
.ends

* Black-box entry subcircuit for sky130_fd_sc_hd__and2_1 abstract view
.subckt sky130_fd_sc_hd__and2_1 A B VGND VNB VPB VPWR X
.ends

* Black-box entry subcircuit for sky130_fd_sc_hd__buf_2 abstract view
.subckt sky130_fd_sc_hd__buf_2 A VGND VNB VPB VPWR X
.ends

* Black-box entry subcircuit for sky130_fd_sc_hd__a21bo_1 abstract view
.subckt sky130_fd_sc_hd__a21bo_1 A1 A2 B1_N VGND VNB VPB VPWR X
.ends

* Black-box entry subcircuit for sky130_fd_sc_hd__or3_1 abstract view
.subckt sky130_fd_sc_hd__or3_1 A B C VGND VNB VPB VPWR X
.ends

.subckt uart_top VGND VPWR clk data[0] data[1] data[2] data[3] data[4] data[5] data[6]
+ data[7] rst rx_data[0] rx_data[1] rx_data[2] rx_data[3] rx_data[4] rx_data[5] rx_data[6]
+ rx_data[7] rx_done tx tx_done tx_start
XFILLER_0_13_51 VGND VGND VPWR VPWR sky130_fd_sc_hd__decap_4
XFILLER_0_10_85 VGND VGND VPWR VPWR sky130_fd_sc_hd__fill_2
X_277_ clknet_2_1__leaf_clk _062_ _031_ VGND VGND VPWR VPWR txu.shift_reg\[6\] sky130_fd_sc_hd__dfstp_1
X_200_ _091_ _092_ txu.bit_count\[0\] VGND VGND VPWR VPWR _116_ sky130_fd_sc_hd__mux2_1
X_131_ net24 _072_ _076_ VGND VGND VPWR VPWR _005_ sky130_fd_sc_hd__nor3_1
Xoutput20 net20 VGND VGND VPWR VPWR tx sky130_fd_sc_hd__clkbuf_4
XFILLER_0_5_106 VGND VGND VPWR VPWR sky130_fd_sc_hd__fill_1
XFILLER_0_13_96 VGND VGND VPWR VPWR sky130_fd_sc_hd__fill_1
X_276_ clknet_2_3__leaf_clk _061_ _030_ VGND VGND VPWR VPWR txu.shift_reg\[5\] sky130_fd_sc_hd__dfstp_1
X_130_ _074_ VGND VGND VPWR VPWR _076_ sky130_fd_sc_hd__clkbuf_4
X_259_ clknet_2_3__leaf_clk _044_ _013_ VGND VGND VPWR VPWR txu.bit_count\[2\] sky130_fd_sc_hd__dfrtp_1
Xoutput21 net21 VGND VGND VPWR VPWR tx_done sky130_fd_sc_hd__clkbuf_4
XFILLER_0_16_85 VGND VGND VPWR VPWR sky130_fd_sc_hd__fill_1
X_275_ clknet_2_3__leaf_clk _060_ _029_ VGND VGND VPWR VPWR txu.shift_reg\[4\] sky130_fd_sc_hd__dfstp_1
X_189_ net20 _092_ _109_ _091_ VGND VGND VPWR VPWR _047_ sky130_fd_sc_hd__a22o_1
X_258_ clknet_2_2__leaf_clk _043_ _012_ VGND VGND VPWR VPWR txu.bit_count\[1\] sky130_fd_sc_hd__dfrtp_1
XFILLER_0_1_63 VGND VGND VPWR VPWR sky130_fd_sc_hd__decap_3
Xoutput11 net11 VGND VGND VPWR VPWR rx_data[0] sky130_fd_sc_hd__clkbuf_4
XFILLER_0_16_75 VGND VGND VPWR VPWR sky130_fd_sc_hd__fill_1
XFILLER_0_9_3 VGND VGND VPWR VPWR sky130_fd_sc_hd__decap_8
XFILLER_0_7_84 VGND VGND VPWR VPWR sky130_fd_sc_hd__decap_3
X_274_ clknet_2_3__leaf_clk _059_ _028_ VGND VGND VPWR VPWR txu.shift_reg\[3\] sky130_fd_sc_hd__dfstp_1
XFILLER_0_10_77 VGND VGND VPWR VPWR sky130_fd_sc_hd__fill_2
XFILLER_0_10_22 VGND VGND VPWR VPWR sky130_fd_sc_hd__decap_6
X_188_ txu.shift_reg\[0\] _084_ VGND VGND VPWR VPWR _109_ sky130_fd_sc_hd__or2_1
X_257_ clknet_2_2__leaf_clk _042_ _011_ VGND VGND VPWR VPWR txu.bit_count\[0\] sky130_fd_sc_hd__dfrtp_1
XFILLER_0_8_106 VGND VGND VPWR VPWR sky130_fd_sc_hd__fill_1
Xoutput12 net12 VGND VGND VPWR VPWR rx_data[1] sky130_fd_sc_hd__clkbuf_4
XFILLER_0_13_77 VGND VGND VPWR VPWR sky130_fd_sc_hd__decap_4
XFILLER_0_13_55 VGND VGND VPWR VPWR sky130_fd_sc_hd__fill_1
X_187_ _108_ VGND VGND VPWR VPWR _048_ sky130_fd_sc_hd__clkbuf_1
X_273_ clknet_2_3__leaf_clk _058_ _027_ VGND VGND VPWR VPWR txu.shift_reg\[2\] sky130_fd_sc_hd__dfstp_1
X_256_ clknet_2_1__leaf_clk _000_ _010_ VGND VGND VPWR VPWR bg.baud_tick sky130_fd_sc_hd__dfrtp_4
X_239_ _125_ VGND VGND VPWR VPWR _029_ sky130_fd_sc_hd__inv_2
Xoutput13 net13 VGND VGND VPWR VPWR rx_data[2] sky130_fd_sc_hd__clkbuf_4
XFILLER_0_13_45 VGND VGND VPWR VPWR sky130_fd_sc_hd__decap_3
X_272_ clknet_2_2__leaf_clk _057_ _026_ VGND VGND VPWR VPWR txu.shift_reg\[1\] sky130_fd_sc_hd__dfstp_1
X_186_ net12 net11 _076_ VGND VGND VPWR VPWR _108_ sky130_fd_sc_hd__mux2_1
X_255_ clknet_2_1__leaf_clk _004_ _009_ VGND VGND VPWR VPWR bg.count\[3\] sky130_fd_sc_hd__dfrtp_1
X_238_ _125_ VGND VGND VPWR VPWR _028_ sky130_fd_sc_hd__inv_2
XFILLER_0_12_103 VGND VGND VPWR VPWR sky130_fd_sc_hd__decap_4
X_169_ net1 _088_ _091_ txu.shift_reg\[2\] VGND VGND VPWR VPWR _100_ sky130_fd_sc_hd__a22o_1
XFILLER_0_13_57 VGND VGND VPWR VPWR sky130_fd_sc_hd__decap_3
XPHY_0 VGND VGND VPWR VPWR sky130_fd_sc_hd__decap_3
Xoutput14 net14 VGND VGND VPWR VPWR rx_data[3] sky130_fd_sc_hd__clkbuf_4
X_254_ clknet_2_1__leaf_clk _003_ _008_ VGND VGND VPWR VPWR bg.count\[2\] sky130_fd_sc_hd__dfrtp_1
X_271_ clknet_2_2__leaf_clk _056_ _025_ VGND VGND VPWR VPWR txu.shift_reg\[0\] sky130_fd_sc_hd__dfstp_1
X_185_ _107_ VGND VGND VPWR VPWR _049_ sky130_fd_sc_hd__clkbuf_1
X_168_ net2 _087_ _089_ txu.shift_reg\[3\] _099_ VGND VGND VPWR VPWR _058_ sky130_fd_sc_hd__o221a_1
X_237_ _125_ VGND VGND VPWR VPWR _027_ sky130_fd_sc_hd__inv_2
XPHY_1 VGND VGND VPWR VPWR sky130_fd_sc_hd__decap_3
Xoutput15 net15 VGND VGND VPWR VPWR rx_data[4] sky130_fd_sc_hd__clkbuf_4
XFILLER_0_13_25 VGND VGND VPWR VPWR sky130_fd_sc_hd__decap_4
X_270_ clknet_2_1__leaf_clk _055_ _024_ VGND VGND VPWR VPWR net18 sky130_fd_sc_hd__dfrtp_1
X_253_ clknet_2_1__leaf_clk _002_ _007_ VGND VGND VPWR VPWR bg.count\[1\] sky130_fd_sc_hd__dfrtp_1
XFILLER_0_10_15 VGND VGND VPWR VPWR sky130_fd_sc_hd__fill_1
X_184_ net13 net12 _076_ VGND VGND VPWR VPWR _107_ sky130_fd_sc_hd__mux2_1
XFILLER_0_4_23 VGND VGND VPWR VPWR sky130_fd_sc_hd__fill_2
X_167_ txu.shift_reg\[2\] _085_ VGND VGND VPWR VPWR _099_ sky130_fd_sc_hd__or2_1
X_236_ _125_ VGND VGND VPWR VPWR _026_ sky130_fd_sc_hd__inv_2
X_219_ _123_ VGND VGND VPWR VPWR _011_ sky130_fd_sc_hd__inv_2
Xoutput16 net16 VGND VGND VPWR VPWR rx_data[5] sky130_fd_sc_hd__clkbuf_4
Xclkbuf_0_clk clk VGND VGND VPWR VPWR clknet_0_clk sky130_fd_sc_hd__clkbuf_16
XFILLER_0_7_23 VGND VGND VPWR VPWR sky130_fd_sc_hd__fill_2
XPHY_2 VGND VGND VPWR VPWR sky130_fd_sc_hd__decap_3
XFILLER_0_4_57 VGND VGND VPWR VPWR sky130_fd_sc_hd__decap_4
X_252_ clknet_2_1__leaf_clk _001_ _006_ VGND VGND VPWR VPWR bg.count\[0\] sky130_fd_sc_hd__dfrtp_2
X_166_ net3 _087_ _089_ txu.shift_reg\[4\] _098_ VGND VGND VPWR VPWR _059_ sky130_fd_sc_hd__o221a_1
X_235_ _122_ VGND VGND VPWR VPWR _125_ sky130_fd_sc_hd__buf_4
XFILLER_0_1_69 VGND VGND VPWR VPWR sky130_fd_sc_hd__fill_1
X_183_ _106_ VGND VGND VPWR VPWR _050_ sky130_fd_sc_hd__clkbuf_1
Xoutput17 net17 VGND VGND VPWR VPWR rx_data[6] sky130_fd_sc_hd__clkbuf_4
X_218_ _123_ VGND VGND VPWR VPWR _010_ sky130_fd_sc_hd__inv_2
X_149_ txu.busy net10 VGND VGND VPWR VPWR _088_ sky130_fd_sc_hd__nor2b_2
XFILLER_0_16_3 VGND VGND VPWR VPWR sky130_fd_sc_hd__fill_1
XPHY_3 VGND VGND VPWR VPWR sky130_fd_sc_hd__decap_3
Xclkbuf_2_0__f_clk clknet_0_clk VGND VGND VPWR VPWR clknet_2_0__leaf_clk sky130_fd_sc_hd__clkbuf_16
X_182_ net14 net13 _076_ VGND VGND VPWR VPWR _106_ sky130_fd_sc_hd__mux2_1
X_251_ _122_ VGND VGND VPWR VPWR _041_ sky130_fd_sc_hd__inv_2
X_165_ txu.shift_reg\[3\] _085_ VGND VGND VPWR VPWR _098_ sky130_fd_sc_hd__or2_1
X_148_ _083_ _086_ _087_ VGND VGND VPWR VPWR _066_ sky130_fd_sc_hd__o21ai_1
X_217_ _123_ VGND VGND VPWR VPWR _009_ sky130_fd_sc_hd__inv_2
X_234_ _124_ VGND VGND VPWR VPWR _025_ sky130_fd_sc_hd__inv_2
Xoutput18 net18 VGND VGND VPWR VPWR rx_data[7] sky130_fd_sc_hd__clkbuf_4
XFILLER_0_7_47 VGND VGND VPWR VPWR sky130_fd_sc_hd__fill_1
XPHY_4 VGND VGND VPWR VPWR sky130_fd_sc_hd__decap_3
X_164_ net4 _087_ _089_ txu.shift_reg\[5\] _097_ VGND VGND VPWR VPWR _060_ sky130_fd_sc_hd__o221a_1
X_233_ _124_ VGND VGND VPWR VPWR _024_ sky130_fd_sc_hd__inv_2
XFILLER_0_10_29 VGND VGND VPWR VPWR sky130_fd_sc_hd__decap_8
X_250_ _122_ VGND VGND VPWR VPWR _040_ sky130_fd_sc_hd__inv_2
X_181_ _105_ VGND VGND VPWR VPWR _051_ sky130_fd_sc_hd__clkbuf_1
XFILLER_0_15_105 VGND VGND VPWR VPWR sky130_fd_sc_hd__fill_2
X_216_ _123_ VGND VGND VPWR VPWR _008_ sky130_fd_sc_hd__inv_2
X_147_ _083_ net10 VGND VGND VPWR VPWR _087_ sky130_fd_sc_hd__nand2_2
Xoutput19 net19 VGND VGND VPWR VPWR rx_done sky130_fd_sc_hd__clkbuf_4
XPHY_5 VGND VGND VPWR VPWR sky130_fd_sc_hd__decap_3
XFILLER_0_4_105 VGND VGND VPWR VPWR sky130_fd_sc_hd__fill_2
X_180_ net15 net14 _076_ VGND VGND VPWR VPWR _105_ sky130_fd_sc_hd__mux2_1
X_163_ txu.shift_reg\[4\] _085_ VGND VGND VPWR VPWR _097_ sky130_fd_sc_hd__or2_1
X_232_ _124_ VGND VGND VPWR VPWR _023_ sky130_fd_sc_hd__inv_2
XFILLER_0_11_51 VGND VGND VPWR VPWR sky130_fd_sc_hd__fill_2
XFILLER_0_17_83 VGND VGND VPWR VPWR sky130_fd_sc_hd__fill_1
X_215_ _123_ VGND VGND VPWR VPWR _007_ sky130_fd_sc_hd__inv_2
X_146_ _083_ _084_ _085_ VGND VGND VPWR VPWR _086_ sky130_fd_sc_hd__o21a_1
X_129_ _072_ _073_ _074_ VGND VGND VPWR VPWR _075_ sky130_fd_sc_hd__mux2_1
XPHY_6 VGND VGND VPWR VPWR sky130_fd_sc_hd__decap_3
XFILLER_0_4_39 VGND VGND VPWR VPWR sky130_fd_sc_hd__decap_6
X_231_ _124_ VGND VGND VPWR VPWR _022_ sky130_fd_sc_hd__inv_2
X_162_ net5 _087_ _089_ txu.shift_reg\[6\] _096_ VGND VGND VPWR VPWR _061_ sky130_fd_sc_hd__o221a_1
Xinput1 data[0] VGND VGND VPWR VPWR net1 sky130_fd_sc_hd__clkbuf_1
X_214_ _123_ VGND VGND VPWR VPWR _006_ sky130_fd_sc_hd__inv_2
XFILLER_0_11_96 VGND VGND VPWR VPWR sky130_fd_sc_hd__fill_2
X_145_ net10 bg.baud_tick txu.busy VGND VGND VPWR VPWR _085_ sky130_fd_sc_hd__mux2_1
XFILLER_0_2_50 VGND VGND VPWR VPWR sky130_fd_sc_hd__fill_1
XFILLER_0_2_83 VGND VGND VPWR VPWR sky130_fd_sc_hd__fill_1
X_128_ rxu.busy bg.baud_tick VGND VGND VPWR VPWR _074_ sky130_fd_sc_hd__nand2_1
XPHY_7 VGND VGND VPWR VPWR sky130_fd_sc_hd__decap_3
XFILLER_0_14_85 VGND VGND VPWR VPWR sky130_fd_sc_hd__fill_1
Xinput2 data[1] VGND VGND VPWR VPWR net2 sky130_fd_sc_hd__clkbuf_1
X_161_ txu.shift_reg\[5\] _085_ VGND VGND VPWR VPWR _096_ sky130_fd_sc_hd__or2_1
X_230_ _124_ VGND VGND VPWR VPWR _021_ sky130_fd_sc_hd__inv_2
XFILLER_0_17_85 VPWR VGND VPWR VGND sky130_ef_sc_hd__decap_12
XFILLER_0_17_52 VGND VGND VPWR VPWR sky130_fd_sc_hd__decap_4
X_144_ txu.bit_count\[2\] txu.bit_count\[1\] txu.bit_count\[0\] txu.bit_count\[3\]
+ VGND VGND VPWR VPWR _084_ sky130_fd_sc_hd__and4bb_1
X_127_ net20 bg.baud_tick VGND VGND VPWR VPWR _073_ sky130_fd_sc_hd__or2b_1
XPHY_8 VGND VGND VPWR VPWR sky130_fd_sc_hd__decap_3
X_213_ _122_ VGND VGND VPWR VPWR _123_ sky130_fd_sc_hd__buf_4
XFILLER_0_8_83 VGND VGND VPWR VPWR sky130_fd_sc_hd__fill_1
XFILLER_0_5_84 VGND VGND VPWR VPWR sky130_fd_sc_hd__decap_4
X_143_ txu.busy VGND VGND VPWR VPWR _083_ sky130_fd_sc_hd__inv_2
XFILLER_0_11_101 VGND VGND VPWR VPWR sky130_fd_sc_hd__decap_3
X_160_ net6 _087_ _089_ txu.shift_reg\[7\] _095_ VGND VGND VPWR VPWR _062_ sky130_fd_sc_hd__o221a_1
Xinput3 data[2] VGND VGND VPWR VPWR net3 sky130_fd_sc_hd__clkbuf_1
X_212_ net9 VGND VGND VPWR VPWR _122_ sky130_fd_sc_hd__clkbuf_4
XFILLER_0_17_97 VGND VGND VPWR VPWR sky130_fd_sc_hd__fill_1
X_126_ rxu.bit_count\[2\] rxu.bit_count\[1\] rxu.bit_count\[0\] VGND VGND VPWR VPWR
+ _072_ sky130_fd_sc_hd__nand3_1
XPHY_9 VGND VGND VPWR VPWR sky130_fd_sc_hd__decap_3
XFILLER_0_14_10 VGND VGND VPWR VPWR sky130_fd_sc_hd__fill_1
XFILLER_0_14_6 VGND VGND VPWR VPWR sky130_fd_sc_hd__decap_4
XFILLER_0_12_3 VGND VGND VPWR VPWR sky130_fd_sc_hd__fill_1
XFILLER_0_5_9 VGND VGND VPWR VPWR sky130_fd_sc_hd__fill_1
XFILLER_0_3_6 VGND VGND VPWR VPWR sky130_fd_sc_hd__fill_1
XTAP_60 VGND VPWR sky130_fd_sc_hd__tapvpwrvgnd_1
Xinput4 data[3] VGND VGND VPWR VPWR net4 sky130_fd_sc_hd__clkbuf_1
Xclkbuf_2_1__f_clk clknet_0_clk VGND VGND VPWR VPWR clknet_2_1__leaf_clk sky130_fd_sc_hd__clkbuf_16
XFILLER_0_1_3 VGND VGND VPWR VPWR sky130_fd_sc_hd__fill_1
X_211_ net23 _120_ VGND VGND VPWR VPWR _004_ sky130_fd_sc_hd__xor2_1
X_142_ rxu.busy _081_ _005_ VGND VGND VPWR VPWR _067_ sky130_fd_sc_hd__o21ba_1
XFILLER_0_17_65 VGND VGND VPWR VPWR sky130_fd_sc_hd__fill_1
XTAP_61 VGND VPWR sky130_fd_sc_hd__tapvpwrvgnd_1
X_210_ bg.count\[2\] _118_ _121_ VGND VGND VPWR VPWR _003_ sky130_fd_sc_hd__o21a_1
Xinput5 data[4] VGND VGND VPWR VPWR net5 sky130_fd_sc_hd__clkbuf_1
XFILLER_0_11_23 VGND VGND VPWR VPWR sky130_fd_sc_hd__fill_1
XTAP_50 VGND VPWR sky130_fd_sc_hd__tapvpwrvgnd_1
X_141_ rxu.bit_count\[0\] _080_ _082_ VGND VGND VPWR VPWR _068_ sky130_fd_sc_hd__o21ba_1
X_287_ clknet_2_0__leaf_clk _071_ _041_ VGND VGND VPWR VPWR rxu.bit_count\[3\] sky130_fd_sc_hd__dfrtp_1
XFILLER_0_2_54 VGND VGND VPWR VPWR sky130_fd_sc_hd__fill_2
XFILLER_0_14_78 VGND VGND VPWR VPWR sky130_fd_sc_hd__fill_1
XFILLER_0_11_57 VGND VGND VPWR VPWR sky130_fd_sc_hd__fill_2
X_286_ clknet_2_0__leaf_clk _070_ _040_ VGND VGND VPWR VPWR rxu.bit_count\[2\] sky130_fd_sc_hd__dfrtp_1
XTAP_62 VGND VPWR sky130_fd_sc_hd__tapvpwrvgnd_1
X_269_ clknet_2_1__leaf_clk _054_ _023_ VGND VGND VPWR VPWR net17 sky130_fd_sc_hd__dfrtp_1
XTAP_51 VGND VPWR sky130_fd_sc_hd__tapvpwrvgnd_1
X_140_ rxu.bit_count\[1\] _082_ _078_ VGND VGND VPWR VPWR _069_ sky130_fd_sc_hd__o21a_1
XTAP_40 VGND VPWR sky130_fd_sc_hd__tapvpwrvgnd_1
Xinput6 data[5] VGND VGND VPWR VPWR net6 sky130_fd_sc_hd__clkbuf_1
XTAP_63 VGND VPWR sky130_fd_sc_hd__tapvpwrvgnd_1
XFILLER_0_11_47 VGND VGND VPWR VPWR sky130_fd_sc_hd__fill_1
XTAP_52 VGND VPWR sky130_fd_sc_hd__tapvpwrvgnd_1
X_285_ clknet_2_0__leaf_clk _069_ _039_ VGND VGND VPWR VPWR rxu.bit_count\[1\] sky130_fd_sc_hd__dfrtp_1
Xinput7 data[6] VGND VGND VPWR VPWR net7 sky130_fd_sc_hd__clkbuf_1
XTAP_41 VGND VPWR sky130_fd_sc_hd__tapvpwrvgnd_1
XFILLER_0_17_79 VGND VGND VPWR VPWR sky130_fd_sc_hd__decap_4
XFILLER_0_17_57 VGND VGND VPWR VPWR sky130_fd_sc_hd__decap_8
X_268_ clknet_2_1__leaf_clk _053_ _022_ VGND VGND VPWR VPWR net16 sky130_fd_sc_hd__dfrtp_1
Xinput10 tx_start VGND VGND VPWR VPWR net10 sky130_fd_sc_hd__buf_1
XFILLER_0_2_23 VGND VGND VPWR VPWR sky130_fd_sc_hd__fill_2
X_199_ _091_ _114_ _115_ _092_ txu.bit_count\[1\] VGND VGND VPWR VPWR _043_ sky130_fd_sc_hd__a32o_1
X_284_ clknet_2_0__leaf_clk _068_ _038_ VGND VGND VPWR VPWR rxu.bit_count\[0\] sky130_fd_sc_hd__dfrtp_1
XTAP_64 VGND VPWR sky130_fd_sc_hd__tapvpwrvgnd_1
XTAP_53 VGND VPWR sky130_fd_sc_hd__tapvpwrvgnd_1
X_198_ txu.bit_count\[1\] txu.bit_count\[0\] VGND VGND VPWR VPWR _115_ sky130_fd_sc_hd__or2_1
Xinput8 data[7] VGND VGND VPWR VPWR net8 sky130_fd_sc_hd__clkbuf_1
X_267_ clknet_2_0__leaf_clk _052_ _021_ VGND VGND VPWR VPWR net15 sky130_fd_sc_hd__dfrtp_1
XTAP_42 VGND VPWR sky130_fd_sc_hd__tapvpwrvgnd_1
XFILLER_0_17_69 VGND VGND VPWR VPWR sky130_fd_sc_hd__decap_4
XFILLER_0_0_106 VGND VGND VPWR VPWR sky130_fd_sc_hd__fill_1
XTAP_65 VGND VPWR sky130_fd_sc_hd__tapvpwrvgnd_1
XTAP_54 VGND VPWR sky130_fd_sc_hd__tapvpwrvgnd_1
X_283_ clknet_2_0__leaf_clk _067_ _037_ VGND VGND VPWR VPWR rxu.busy sky130_fd_sc_hd__dfrtp_1
Xinput9 rst VGND VGND VPWR VPWR net9 sky130_fd_sc_hd__clkbuf_1
XTAP_43 VGND VPWR sky130_fd_sc_hd__tapvpwrvgnd_1
X_197_ txu.bit_count\[1\] txu.bit_count\[0\] VGND VGND VPWR VPWR _114_ sky130_fd_sc_hd__nand2_1
X_249_ _122_ VGND VGND VPWR VPWR _039_ sky130_fd_sc_hd__inv_2
X_266_ clknet_2_0__leaf_clk _051_ _020_ VGND VGND VPWR VPWR net14 sky130_fd_sc_hd__dfrtp_1
Xhold1 bg.count\[0\] VGND VGND VPWR VPWR net22 sky130_fd_sc_hd__dlygate4sd3_1
XTAP_55 VGND VPWR sky130_fd_sc_hd__tapvpwrvgnd_1
X_196_ txu.bit_count\[2\] _110_ _113_ VGND VGND VPWR VPWR _044_ sky130_fd_sc_hd__o21a_1
X_265_ clknet_2_0__leaf_clk _050_ _019_ VGND VGND VPWR VPWR net13 sky130_fd_sc_hd__dfrtp_1
X_282_ clknet_2_0__leaf_clk _005_ _036_ VGND VGND VPWR VPWR net19 sky130_fd_sc_hd__dfrtp_1
XTAP_44 VGND VPWR sky130_fd_sc_hd__tapvpwrvgnd_1
XFILLER_0_12_82 VGND VGND VPWR VPWR sky130_fd_sc_hd__fill_2
X_248_ _122_ VGND VGND VPWR VPWR _038_ sky130_fd_sc_hd__inv_2
X_179_ _104_ VGND VGND VPWR VPWR _052_ sky130_fd_sc_hd__clkbuf_1
Xclkbuf_2_2__f_clk clknet_0_clk VGND VGND VPWR VPWR clknet_2_2__leaf_clk sky130_fd_sc_hd__clkbuf_16
Xhold2 bg.count\[3\] VGND VGND VPWR VPWR net23 sky130_fd_sc_hd__dlygate4sd3_1
XTAP_56 VGND VPWR sky130_fd_sc_hd__tapvpwrvgnd_1
X_281_ clknet_2_3__leaf_clk _066_ _035_ VGND VGND VPWR VPWR txu.busy sky130_fd_sc_hd__dfrtp_4
XFILLER_0_8_3 VGND VGND VPWR VPWR sky130_fd_sc_hd__fill_2
XTAP_45 VGND VPWR sky130_fd_sc_hd__tapvpwrvgnd_1
X_195_ txu.bit_count\[2\] _110_ _088_ VGND VGND VPWR VPWR _113_ sky130_fd_sc_hd__a21oi_1
X_247_ _122_ VGND VGND VPWR VPWR _037_ sky130_fd_sc_hd__inv_2
X_264_ clknet_2_0__leaf_clk _049_ _018_ VGND VGND VPWR VPWR net12 sky130_fd_sc_hd__dfrtp_1
XFILLER_0_3_106 VGND VGND VPWR VPWR sky130_fd_sc_hd__fill_1
X_178_ net16 net15 _076_ VGND VGND VPWR VPWR _104_ sky130_fd_sc_hd__mux2_1
Xhold3 rxu.bit_count\[3\] VGND VGND VPWR VPWR net24 sky130_fd_sc_hd__dlygate4sd3_1
XFILLER_0_5_16 VGND VGND VPWR VPWR sky130_fd_sc_hd__fill_1
X_263_ clknet_2_1__leaf_clk _048_ _017_ VGND VGND VPWR VPWR net11 sky130_fd_sc_hd__dfrtp_1
XPHY_30 VGND VGND VPWR VPWR sky130_fd_sc_hd__decap_3
XTAP_57 VGND VPWR sky130_fd_sc_hd__tapvpwrvgnd_1
XTAP_46 VGND VPWR sky130_fd_sc_hd__tapvpwrvgnd_1
X_194_ _088_ _111_ _112_ VGND VGND VPWR VPWR _045_ sky130_fd_sc_hd__nor3_1
X_280_ clknet_2_2__leaf_clk _065_ _034_ VGND VGND VPWR VPWR txu.shift_reg\[9\] sky130_fd_sc_hd__dfstp_1
XFILLER_0_17_29 VGND VGND VPWR VPWR sky130_fd_sc_hd__fill_2
X_177_ _103_ VGND VGND VPWR VPWR _053_ sky130_fd_sc_hd__clkbuf_1
X_246_ _122_ VGND VGND VPWR VPWR _036_ sky130_fd_sc_hd__inv_2
X_229_ _124_ VGND VGND VPWR VPWR _020_ sky130_fd_sc_hd__inv_2
XTAP_58 VGND VPWR sky130_fd_sc_hd__tapvpwrvgnd_1
XFILLER_0_10_9 VGND VGND VPWR VPWR sky130_fd_sc_hd__decap_6
XTAP_47 VGND VPWR sky130_fd_sc_hd__tapvpwrvgnd_1
XTAP_36 VGND VPWR sky130_fd_sc_hd__tapvpwrvgnd_1
XFILLER_0_0_72 VGND VGND VPWR VPWR sky130_fd_sc_hd__fill_2
XFILLER_0_0_83 VGND VGND VPWR VPWR sky130_fd_sc_hd__fill_1
XFILLER_0_17_19 VGND VGND VPWR VPWR sky130_fd_sc_hd__fill_1
XPHY_31 VGND VGND VPWR VPWR sky130_fd_sc_hd__decap_3
XPHY_20 VGND VGND VPWR VPWR sky130_fd_sc_hd__decap_3
X_262_ clknet_2_2__leaf_clk _047_ _016_ VGND VGND VPWR VPWR net20 sky130_fd_sc_hd__dfstp_1
X_193_ txu.bit_count\[2\] _110_ txu.bit_count\[3\] VGND VGND VPWR VPWR _112_ sky130_fd_sc_hd__a21oi_1
X_176_ net17 net16 _076_ VGND VGND VPWR VPWR _103_ sky130_fd_sc_hd__mux2_1
X_245_ _125_ VGND VGND VPWR VPWR _035_ sky130_fd_sc_hd__inv_2
X_159_ txu.shift_reg\[6\] _085_ VGND VGND VPWR VPWR _095_ sky130_fd_sc_hd__or2_1
X_228_ _124_ VGND VGND VPWR VPWR _019_ sky130_fd_sc_hd__inv_2
XFILLER_0_17_3 VGND VGND VPWR VPWR sky130_fd_sc_hd__fill_1
X_261_ clknet_2_3__leaf_clk _046_ _015_ VGND VGND VPWR VPWR net21 sky130_fd_sc_hd__dfrtp_1
XPHY_32 VGND VGND VPWR VPWR sky130_fd_sc_hd__decap_3
XTAP_59 VGND VPWR sky130_fd_sc_hd__tapvpwrvgnd_1
XPHY_21 VGND VGND VPWR VPWR sky130_fd_sc_hd__decap_3
X_192_ txu.bit_count\[3\] txu.bit_count\[2\] _110_ VGND VGND VPWR VPWR _111_ sky130_fd_sc_hd__and3_1
XTAP_48 VGND VPWR sky130_fd_sc_hd__tapvpwrvgnd_1
XFILLER_0_6_3 VGND VGND VPWR VPWR sky130_fd_sc_hd__fill_2
XPHY_10 VGND VGND VPWR VPWR sky130_fd_sc_hd__decap_3
XTAP_37 VGND VPWR sky130_fd_sc_hd__tapvpwrvgnd_1
X_175_ _102_ VGND VGND VPWR VPWR _054_ sky130_fd_sc_hd__clkbuf_1
XFILLER_0_6_106 VGND VGND VPWR VPWR sky130_fd_sc_hd__fill_1
X_244_ _125_ VGND VGND VPWR VPWR _034_ sky130_fd_sc_hd__inv_2
X_227_ _124_ VGND VGND VPWR VPWR _018_ sky130_fd_sc_hd__inv_2
X_158_ txu.shift_reg\[7\] _092_ _094_ VGND VGND VPWR VPWR _063_ sky130_fd_sc_hd__a21o_1
XFILLER_0_9_50 VGND VGND VPWR VPWR sky130_fd_sc_hd__decap_6
XTAP_49 VGND VPWR sky130_fd_sc_hd__tapvpwrvgnd_1
XFILLER_0_0_63 VGND VGND VPWR VPWR sky130_fd_sc_hd__decap_3
XTAP_38 VGND VPWR sky130_fd_sc_hd__tapvpwrvgnd_1
XPHY_33 VGND VGND VPWR VPWR sky130_fd_sc_hd__decap_3
XFILLER_0_12_76 VGND VGND VPWR VPWR sky130_fd_sc_hd__decap_3
XPHY_22 VGND VGND VPWR VPWR sky130_fd_sc_hd__decap_3
X_191_ bg.baud_tick txu.busy txu.bit_count\[1\] txu.bit_count\[0\] VGND VGND VPWR
+ VPWR _110_ sky130_fd_sc_hd__and4_1
X_260_ clknet_2_2__leaf_clk _045_ _014_ VGND VGND VPWR VPWR txu.bit_count\[3\] sky130_fd_sc_hd__dfrtp_1
XPHY_11 VGND VGND VPWR VPWR sky130_fd_sc_hd__decap_3
X_174_ net18 net17 _076_ VGND VGND VPWR VPWR _102_ sky130_fd_sc_hd__mux2_1
X_226_ _124_ VGND VGND VPWR VPWR _017_ sky130_fd_sc_hd__inv_2
X_243_ _125_ VGND VGND VPWR VPWR _033_ sky130_fd_sc_hd__inv_2
X_157_ net7 _088_ _091_ txu.shift_reg\[8\] VGND VGND VPWR VPWR _094_ sky130_fd_sc_hd__a22o_1
XFILLER_0_3_63 VGND VGND VPWR VPWR sky130_fd_sc_hd__fill_1
X_209_ _000_ _120_ VGND VGND VPWR VPWR _121_ sky130_fd_sc_hd__nor2_1
XFILLER_0_15_54 VGND VGND VPWR VPWR sky130_fd_sc_hd__fill_2
XFILLER_0_13_100 VGND VGND VPWR VPWR sky130_fd_sc_hd__fill_1
XFILLER_0_6_96 VGND VGND VPWR VPWR sky130_fd_sc_hd__fill_2
XFILLER_0_6_85 VGND VGND VPWR VPWR sky130_fd_sc_hd__fill_1
XPHY_12 VGND VGND VPWR VPWR sky130_fd_sc_hd__decap_3
XTAP_39 VGND VPWR sky130_fd_sc_hd__tapvpwrvgnd_1
XPHY_34 VGND VGND VPWR VPWR sky130_fd_sc_hd__decap_3
X_190_ net21 _086_ _087_ VGND VGND VPWR VPWR _046_ sky130_fd_sc_hd__o21a_1
XFILLER_0_12_88 VPWR VGND VPWR VGND sky130_ef_sc_hd__decap_12
XPHY_23 VGND VGND VPWR VPWR sky130_fd_sc_hd__decap_3
X_173_ _101_ VGND VGND VPWR VPWR _055_ sky130_fd_sc_hd__clkbuf_1
X_242_ _125_ VGND VGND VPWR VPWR _032_ sky130_fd_sc_hd__inv_2
X_225_ _124_ VGND VGND VPWR VPWR _016_ sky130_fd_sc_hd__inv_2
X_156_ txu.shift_reg\[8\] _092_ _093_ VGND VGND VPWR VPWR _064_ sky130_fd_sc_hd__a21o_1
XFILLER_0_15_3 VGND VGND VPWR VPWR sky130_fd_sc_hd__fill_2
X_208_ bg.count\[1\] bg.count\[0\] bg.count\[2\] VGND VGND VPWR VPWR _120_ sky130_fd_sc_hd__and3_1
Xclkbuf_2_3__f_clk clknet_0_clk VGND VGND VPWR VPWR clknet_2_3__leaf_clk sky130_fd_sc_hd__clkbuf_16
X_139_ _080_ _081_ rxu.bit_count\[0\] VGND VGND VPWR VPWR _082_ sky130_fd_sc_hd__o21a_1
XPHY_35 VGND VGND VPWR VPWR sky130_fd_sc_hd__decap_3
XPHY_24 VGND VGND VPWR VPWR sky130_fd_sc_hd__decap_3
XFILLER_0_9_106 VGND VGND VPWR VPWR sky130_fd_sc_hd__fill_1
XPHY_13 VGND VGND VPWR VPWR sky130_fd_sc_hd__decap_3
X_241_ _125_ VGND VGND VPWR VPWR _031_ sky130_fd_sc_hd__inv_2
X_172_ net18 net20 _080_ VGND VGND VPWR VPWR _101_ sky130_fd_sc_hd__mux2_1
X_155_ net8 _088_ _091_ txu.shift_reg\[9\] VGND VGND VPWR VPWR _093_ sky130_fd_sc_hd__a22o_1
X_224_ _122_ VGND VGND VPWR VPWR _124_ sky130_fd_sc_hd__buf_4
X_207_ _118_ _119_ VGND VGND VPWR VPWR _002_ sky130_fd_sc_hd__nor2_1
XFILLER_0_9_42 VGND VGND VPWR VPWR sky130_fd_sc_hd__decap_4
X_138_ net20 bg.baud_tick VGND VGND VPWR VPWR _081_ sky130_fd_sc_hd__and2b_1
XFILLER_0_0_55 VGND VGND VPWR VPWR sky130_fd_sc_hd__fill_1
X_240_ _125_ VGND VGND VPWR VPWR _030_ sky130_fd_sc_hd__inv_2
XPHY_25 VGND VGND VPWR VPWR sky130_fd_sc_hd__decap_3
XFILLER_0_12_57 VGND VGND VPWR VPWR sky130_fd_sc_hd__decap_8
X_171_ txu.shift_reg\[1\] _091_ _092_ txu.shift_reg\[0\] VGND VGND VPWR VPWR _056_
+ sky130_fd_sc_hd__a22o_1
XPHY_14 VGND VGND VPWR VPWR sky130_fd_sc_hd__decap_3
X_223_ _123_ VGND VGND VPWR VPWR _015_ sky130_fd_sc_hd__inv_2
XFILLER_0_3_22 VGND VGND VPWR VPWR sky130_fd_sc_hd__fill_2
X_154_ _088_ _091_ VGND VGND VPWR VPWR _092_ sky130_fd_sc_hd__nor2_2
X_206_ bg.count\[1\] bg.count\[0\] VGND VGND VPWR VPWR _119_ sky130_fd_sc_hd__nor2_1
X_137_ rxu.busy bg.baud_tick VGND VGND VPWR VPWR _080_ sky130_fd_sc_hd__and2_1
XPHY_26 VGND VGND VPWR VPWR sky130_fd_sc_hd__decap_3
XPHY_15 VGND VGND VPWR VPWR sky130_fd_sc_hd__decap_3
X_170_ txu.shift_reg\[1\] _092_ _100_ VGND VGND VPWR VPWR _057_ sky130_fd_sc_hd__a21o_1
X_205_ bg.count\[1\] bg.count\[0\] VGND VGND VPWR VPWR _118_ sky130_fd_sc_hd__and2_1
XFILLER_0_9_11 VGND VGND VPWR VPWR sky130_fd_sc_hd__fill_2
X_153_ _090_ VGND VGND VPWR VPWR _091_ sky130_fd_sc_hd__buf_2
X_136_ rxu.bit_count\[2\] _078_ _079_ VGND VGND VPWR VPWR _070_ sky130_fd_sc_hd__a21bo_1
X_222_ _123_ VGND VGND VPWR VPWR _014_ sky130_fd_sc_hd__inv_2
XPHY_27 VGND VGND VPWR VPWR sky130_fd_sc_hd__decap_3
XFILLER_0_13_3 VGND VGND VPWR VPWR sky130_fd_sc_hd__decap_6
XPHY_16 VGND VGND VPWR VPWR sky130_fd_sc_hd__decap_3
XFILLER_0_6_78 VGND VGND VPWR VPWR sky130_fd_sc_hd__fill_1
XFILLER_0_6_56 VGND VGND VPWR VPWR sky130_fd_sc_hd__fill_1
X_221_ _123_ VGND VGND VPWR VPWR _013_ sky130_fd_sc_hd__inv_2
X_152_ bg.baud_tick txu.busy VGND VGND VPWR VPWR _090_ sky130_fd_sc_hd__and2_1
X_204_ net22 VGND VGND VPWR VPWR _001_ sky130_fd_sc_hd__inv_2
X_135_ rxu.bit_count\[2\] _077_ _076_ VGND VGND VPWR VPWR _079_ sky130_fd_sc_hd__or3_1
XPHY_28 VGND VGND VPWR VPWR sky130_fd_sc_hd__decap_3
XPHY_17 VGND VGND VPWR VPWR sky130_fd_sc_hd__decap_3
XFILLER_0_13_81 VGND VGND VPWR VPWR sky130_fd_sc_hd__fill_1
XFILLER_0_12_27 VGND VGND VPWR VPWR sky130_fd_sc_hd__fill_1
X_203_ _117_ VGND VGND VPWR VPWR _000_ sky130_fd_sc_hd__clkbuf_1
X_134_ rxu.busy _077_ _076_ _073_ VGND VGND VPWR VPWR _078_ sky130_fd_sc_hd__a22o_1
X_151_ txu.shift_reg\[9\] _088_ _089_ VGND VGND VPWR VPWR _065_ sky130_fd_sc_hd__o21a_1
X_220_ _123_ VGND VGND VPWR VPWR _012_ sky130_fd_sc_hd__inv_2
XFILLER_0_9_57 VGND VGND VPWR VPWR sky130_fd_sc_hd__decap_6
XFILLER_0_9_46 VGND VGND VPWR VPWR sky130_fd_sc_hd__fill_1
XFILLER_0_16_81 VGND VGND VPWR VPWR sky130_fd_sc_hd__decap_3
XPHY_29 VGND VGND VPWR VPWR sky130_fd_sc_hd__decap_3
XPHY_18 VGND VGND VPWR VPWR sky130_fd_sc_hd__decap_3
X_150_ bg.baud_tick txu.busy VGND VGND VPWR VPWR _089_ sky130_fd_sc_hd__nand2_2
X_279_ clknet_2_2__leaf_clk _064_ _033_ VGND VGND VPWR VPWR txu.shift_reg\[8\] sky130_fd_sc_hd__dfstp_1
X_202_ bg.count\[3\] bg.count\[2\] bg.count\[1\] bg.count\[0\] VGND VGND VPWR VPWR
+ _117_ sky130_fd_sc_hd__and4bb_1
X_133_ rxu.bit_count\[1\] rxu.bit_count\[0\] VGND VGND VPWR VPWR _077_ sky130_fd_sc_hd__nand2_1
XFILLER_0_0_27 VGND VGND VPWR VPWR sky130_fd_sc_hd__fill_1
XPHY_19 VGND VGND VPWR VPWR sky130_fd_sc_hd__decap_3
XFILLER_0_0_3 VGND VGND VPWR VPWR sky130_fd_sc_hd__fill_1
X_278_ clknet_2_2__leaf_clk _063_ _032_ VGND VGND VPWR VPWR txu.shift_reg\[7\] sky130_fd_sc_hd__dfstp_1
X_132_ net24 _075_ _005_ VGND VGND VPWR VPWR _071_ sky130_fd_sc_hd__a21o_1
X_201_ _116_ VGND VGND VPWR VPWR _042_ sky130_fd_sc_hd__clkbuf_1
XFILLER_0_6_27 VGND VGND VPWR VPWR sky130_fd_sc_hd__fill_1
.ends
